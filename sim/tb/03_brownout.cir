* 03 Brown-out / input sag and Schottky drop.
* A) VSYS (= LDO IN, after R12 + D2 or Q1/F1 from J1.1) ramps 5.0 V -> 0 V in 50 ms (100 V/s, slow enough to be quasi-static)
*    with a constant-current 3V3 load of 50 mA and 250 mA (current sinks fold back below ~1 V).
*    Current spec.py rail (NL_RAIL_V13, C12 4.7u 0402). Reported: the VSYS (and VBUS =
*    VSYS + VF + I x R12) level where 3V3 drops below 3.20 V (-3 %),
*    3.0 V, 2.0 V (STM32F103 VDD min) and 1.88 V / 1.80 V (PDR falling typ / min).
*    Vendor-model caveat: dropout is a fixed 150 mV (+ 36 mohm) at any load; datasheet is
*    150 mV typ / 215 mV max at 500 mA (~0.30 / 0.43 ohm), so analyze.py also gives the
*    datasheet-max estimate.
* B) D2 1N5819WS forward drop at 100/250/500 mA (DC sweep of the fitted model).
* Pass: the window between VDD < 2.0 V and PDR (out-of-spec operation without reset) is
*   flagged MARGIN unless firmware enables the PVD; Schottky drop at 250 mA leaves LDO headroom
*   at VBUS = 4.40 V.
.include models/parts.lib
.include models/caps.lib
.include models/TLV75533P_TRANS.lib
.include models/board.lib
.param ILOAD=50m
V5 p5s 0 PWL(0 5 5m 5 55m 0)
Rsrc p5s p5 0.05
XC12 p5 0 MLCC C0=4.7u V0=3.1 ESR=10m ESL=0.3n VB=5
XR p5 p3 p3a NL_RAIL_V13
BL p3 0 I = ILOAD*(1-exp(-max(V(p3),0)/0.3))
* --- B) Schottky DC sweep (separate network) ---
Id 0 da DC 0
D2 da 0 D1N5819WS
.ic v(xr.xu2.u1_n08530)=0
.tran 1u 56m 0 20u
.control
compose vl values 50m 250m
let k = 0
while k < length(vl)
  let x = vl[k]
  alterparam ILOAD = $&x
  reset
  run
  set ks = "$&k"
  echo "CASE bo_{$ks} ILOAD=$&x"
  wrdata results/bo_{$ks}.dat v(p5) v(p3)
  destroy all
  let k = k + 1
end
dc Id 1m 600m 1m
wrdata results/schottky_dc.dat v(da)
.endc
.end
